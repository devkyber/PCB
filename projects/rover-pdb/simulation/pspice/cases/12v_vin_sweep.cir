Rover PDB A9 12v vin_sweep -- PREPARED, NOT RUN
* Authentic encrypted TI LMR51450 model. PSpice required.
* Component/model assumptions and limitations: ../README.md
.LIB "../vendor/LMR51450_PSPICE_TRANS/LMR51450_TRANS.lib"
.PARAM VIN_POINT=25.2 I_FULL=3.0 V_TARGET=11.988811189
* Sensitivity parameters; defaults are approximate, not production bounds.
.PARAM C_SCALE=1 CER_ESR=5m BULK_SCALE=1 BULK_ESR_SCALE=1
.PARAM SOURCE_R=50m L_SCALE=1
V_BAT SOURCE 0 PWL(0 0 1m 25.2 12m 25.2 18m 19.8 22m 19.8 28m 25.2 35m 25.2)
* Single-rail upstream source approximation; other rails and C1 omitted.
R_SOURCE SOURCE VIN {SOURCE_R}
R_ESR_C10 VIN C10_ESR {CER_ESR}
C_C10 C10_ESR 0 {5.75u*C_SCALE}
R_ESR_C11 VIN C11_ESR {CER_ESR}
C_C11 C11_ESR 0 {5.75u*C_SCALE}
R_ESR_C30 VIN C30_ESR {CER_ESR}
C_C30 C30_ESR 0 100n
R_R13 VIN EN 100k
* Model pin order: AGND BOOT EN FB GND PGOOD RT SW1 SW2 SW3 VIN1 VIN2 VIN3
* Both ground domains tied at 0 per TI model; cannot evaluate return layout.
* RT_NC and PG_NC intentionally have no external parts, matching A9.
X_U2 0 BOOT EN FB 0 PG_NC RT_NC SW SW SW VIN VIN VIN LMR51450_TRANS PARAMS: MODE=0
C_C33 BOOT SW 100n
L_L1 SW L_DCR {6.8u*L_SCALE}
R_DCR L_DCR VOUT 11.5m
R_R10 VOUT FB 100k
R_R17 FB 0 7.15k
C_C39 VOUT FF 33p
R_R21 FF FB 1k
R_ESR_C20 VOUT C20_ESR {CER_ESR}
C_C20 C20_ESR 0 {8.95u*C_SCALE}
R_ESR_C21 VOUT C21_ESR {CER_ESR}
C_C21 C21_ESR 0 {8.95u*C_SCALE}
R_ESR_C22 VOUT C22_ESR {CER_ESR}
C_C22 C22_ESR 0 {8.95u*C_SCALE}
R_ESR_C23 VOUT C23_ESR {CER_ESR}
C_C23 C23_ESR 0 {8.95u*C_SCALE}
* Resistive planning load: full rated planning current only at target voltage.
R_LOAD VOUT 0 {V_TARGET/I_FULL}
R_NUMERICAL VOUT 0 1G
.TRAN 0 35m 0 20n
.OPTIONS ADVCONV
.OPTIONS ITL4=20
.PROBE64 V(VIN) V(VOUT) V(EN) V(BOOT) V(SW) V(FB)
+ I(L_L1) I(V_BAT)
.MEAS TRAN VOUT_MAX MAX V(VOUT)
.MEAS TRAN IL_MAX MAX I(L_L1)
.END
