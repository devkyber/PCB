Rover PDB A9 5v vin_sweep -- PREPARED, NOT RUN
* Authentic encrypted TI LMR51450 model. PSpice required.
* Component/model assumptions and limitations: ../README.md
.LIB "../vendor/LMR51450_PSPICE_TRANS/LMR51450_TRANS.lib"
.PARAM VIN_POINT=25.2 I_FULL=2.4 V_TARGET=4.988481675
* Sensitivity parameters; defaults are approximate, not production bounds.
.PARAM C_SCALE=1 CER_ESR=5m BULK_SCALE=1 BULK_ESR_SCALE=1
.PARAM SOURCE_R=50m L_SCALE=1
V_BAT SOURCE 0 PWL(0 0 1m 25.2 12m 25.2 18m 19.8 22m 19.8 28m 25.2 35m 25.2)
* Single-rail upstream source approximation; other rails and C1 omitted.
R_SOURCE SOURCE VIN {SOURCE_R}
R_ESR_C12 VIN C12_ESR {CER_ESR}
C_C12 C12_ESR 0 {5.75u*C_SCALE}
R_ESR_C13 VIN C13_ESR {CER_ESR}
C_C13 C13_ESR 0 {5.75u*C_SCALE}
R_ESR_C31 VIN C31_ESR {CER_ESR}
C_C31 C31_ESR 0 100n
R_R14 VIN EN 100k
* Model pin order: AGND BOOT EN FB GND PGOOD RT SW1 SW2 SW3 VIN1 VIN2 VIN3
* Both ground domains tied at 0 per TI model; cannot evaluate return layout.
* RT_NC and PG_NC intentionally have no external parts, matching A9.
X_U3 0 BOOT EN FB 0 PG_NC RT_NC SW SW SW VIN VIN VIN LMR51450_TRANS PARAMS: MODE=0
C_C34 BOOT SW 100n
L_L2 SW L_DCR {4.7u*L_SCALE}
R_DCR L_DCR VOUT 8.4m
R_R11 VOUT FB 100k
R_R16 FB 0 19.1k
C_C40 VOUT FF 33p
R_R22 FF FB 1k
R_ESR_C24 VOUT C24_ESR {CER_ESR}
C_C24 C24_ESR 0 {17.51u*C_SCALE}
R_ESR_C25 VOUT C25_ESR {CER_ESR}
C_C25 C25_ESR 0 {17.51u*C_SCALE}
R_ESR_C26 VOUT C26_ESR {CER_ESR}
C_C26 C26_ESR 0 {17.51u*C_SCALE}
R_ESR_C27 VOUT C27_ESR {CER_ESR}
C_C27 C27_ESR 0 {17.51u*C_SCALE}
R_ESR_C28 VOUT C28_ESR {CER_ESR}
C_C28 C28_ESR 0 {17.51u*C_SCALE}
* Bulk ESR approximates published 100kHz impedance; not a guaranteed ESR model.
R_ESR_C2 VOUT C2_ESR {56m*BULK_ESR_SCALE}
C_C2 C2_ESR 0 {470u*BULK_SCALE}
* Resistive planning load: full rated planning current only at target voltage.
R_LOAD VOUT 0 {V_TARGET/I_FULL}
R_NUMERICAL VOUT 0 1G
.TRAN 0 35m 0 20n
.OPTIONS ADVCONV
.OPTIONS ITL4=20
.PROBE64 V(VIN) V(VOUT) V(EN) V(BOOT) V(SW) V(FB)
+ I(L_L2) I(V_BAT)
.MEAS TRAN VOUT_MAX MAX V(VOUT)
.MEAS TRAN IL_MAX MAX I(L_L2)
.END
